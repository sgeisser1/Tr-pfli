* fluidi RGB-LED-Treiber, erzeugt von led_rgb_drive.py
.include led_models.inc
VDD vdd 0 DC 3.0
D1 vdd a1 DR
VO1 a1 b1 DC {OFF_R_MIN}
RS1 b1 g1 470
RON1 g1 m1 100
VM1 m1 0 DC 0
D2 vdd a2 DR
VO2 a2 b2 DC {OFF_R_MIN}
RS2 b2 g2 470
RON2 g2 m2 40
VM2 m2 0 DC 0
D3 vdd a3 DR
VO3 a3 b3 DC {OFF_R_MID}
RS3 b3 g3 470
RON3 g3 m3 100
VM3 m3 0 DC 0
D4 vdd a4 DR
VO4 a4 b4 DC {OFF_R_MID}
RS4 b4 g4 470
RON4 g4 m4 40
VM4 m4 0 DC 0
D5 vdd a5 DR
VO5 a5 b5 DC {OFF_R_MAX}
RS5 b5 g5 470
RON5 g5 m5 100
VM5 m5 0 DC 0
D6 vdd a6 DR
VO6 a6 b6 DC {OFF_R_MAX}
RS6 b6 g6 470
RON6 g6 m6 40
VM6 m6 0 DC 0
D7 vdd a7 DR
VO7 a7 b7 DC {OFF_R_MIN}
RS7 b7 g7 200
RON7 g7 m7 100
VM7 m7 0 DC 0
D8 vdd a8 DR
VO8 a8 b8 DC {OFF_R_MIN}
RS8 b8 g8 200
RON8 g8 m8 40
VM8 m8 0 DC 0
D9 vdd a9 DR
VO9 a9 b9 DC {OFF_R_MID}
RS9 b9 g9 200
RON9 g9 m9 100
VM9 m9 0 DC 0
D10 vdd a10 DR
VO10 a10 b10 DC {OFF_R_MID}
RS10 b10 g10 200
RON10 g10 m10 40
VM10 m10 0 DC 0
D11 vdd a11 DR
VO11 a11 b11 DC {OFF_R_MAX}
RS11 b11 g11 200
RON11 g11 m11 100
VM11 m11 0 DC 0
D12 vdd a12 DR
VO12 a12 b12 DC {OFF_R_MAX}
RS12 b12 g12 200
RON12 g12 m12 40
VM12 m12 0 DC 0
D13 vdd a13 DG
VO13 a13 b13 DC {OFF_G_MIN}
RS13 b13 g13 470
RON13 g13 m13 100
VM13 m13 0 DC 0
D14 vdd a14 DG
VO14 a14 b14 DC {OFF_G_MIN}
RS14 b14 g14 470
RON14 g14 m14 40
VM14 m14 0 DC 0
D15 vdd a15 DG
VO15 a15 b15 DC {OFF_G_MID}
RS15 b15 g15 470
RON15 g15 m15 100
VM15 m15 0 DC 0
D16 vdd a16 DG
VO16 a16 b16 DC {OFF_G_MID}
RS16 b16 g16 470
RON16 g16 m16 40
VM16 m16 0 DC 0
D17 vdd a17 DG
VO17 a17 b17 DC {OFF_G_MAX}
RS17 b17 g17 470
RON17 g17 m17 100
VM17 m17 0 DC 0
D18 vdd a18 DG
VO18 a18 b18 DC {OFF_G_MAX}
RS18 b18 g18 470
RON18 g18 m18 40
VM18 m18 0 DC 0
D19 vdd a19 DG
VO19 a19 b19 DC {OFF_G_MIN}
RS19 b19 g19 200
RON19 g19 m19 100
VM19 m19 0 DC 0
D20 vdd a20 DG
VO20 a20 b20 DC {OFF_G_MIN}
RS20 b20 g20 200
RON20 g20 m20 40
VM20 m20 0 DC 0
D21 vdd a21 DG
VO21 a21 b21 DC {OFF_G_MID}
RS21 b21 g21 200
RON21 g21 m21 100
VM21 m21 0 DC 0
D22 vdd a22 DG
VO22 a22 b22 DC {OFF_G_MID}
RS22 b22 g22 200
RON22 g22 m22 40
VM22 m22 0 DC 0
D23 vdd a23 DG
VO23 a23 b23 DC {OFF_G_MAX}
RS23 b23 g23 200
RON23 g23 m23 100
VM23 m23 0 DC 0
D24 vdd a24 DG
VO24 a24 b24 DC {OFF_G_MAX}
RS24 b24 g24 200
RON24 g24 m24 40
VM24 m24 0 DC 0
D25 vdd a25 DG
VO25 a25 b25 DC {OFF_G_MIN}
RS25 b25 g25 100
RON25 g25 m25 100
VM25 m25 0 DC 0
D26 vdd a26 DG
VO26 a26 b26 DC {OFF_G_MIN}
RS26 b26 g26 100
RON26 g26 m26 40
VM26 m26 0 DC 0
D27 vdd a27 DG
VO27 a27 b27 DC {OFF_G_MID}
RS27 b27 g27 100
RON27 g27 m27 100
VM27 m27 0 DC 0
D28 vdd a28 DG
VO28 a28 b28 DC {OFF_G_MID}
RS28 b28 g28 100
RON28 g28 m28 40
VM28 m28 0 DC 0
D29 vdd a29 DG
VO29 a29 b29 DC {OFF_G_MAX}
RS29 b29 g29 100
RON29 g29 m29 100
VM29 m29 0 DC 0
D30 vdd a30 DG
VO30 a30 b30 DC {OFF_G_MAX}
RS30 b30 g30 100
RON30 g30 m30 40
VM30 m30 0 DC 0
D31 vdd a31 DB
VO31 a31 b31 DC {OFF_B_MIN}
RS31 b31 g31 100
RON31 g31 m31 100
VM31 m31 0 DC 0
D32 vdd a32 DB
VO32 a32 b32 DC {OFF_B_MIN}
RS32 b32 g32 100
RON32 g32 m32 40
VM32 m32 0 DC 0
D33 vdd a33 DB
VO33 a33 b33 DC {OFF_B_MID}
RS33 b33 g33 100
RON33 g33 m33 100
VM33 m33 0 DC 0
D34 vdd a34 DB
VO34 a34 b34 DC {OFF_B_MID}
RS34 b34 g34 100
RON34 g34 m34 40
VM34 m34 0 DC 0
D35 vdd a35 DB
VO35 a35 b35 DC {OFF_B_MAX}
RS35 b35 g35 100
RON35 g35 m35 100
VM35 m35 0 DC 0
D36 vdd a36 DB
VO36 a36 b36 DC {OFF_B_MAX}
RS36 b36 g36 100
RON36 g36 m36 40
VM36 m36 0 DC 0
D37 vdd a37 DB
VO37 a37 b37 DC {OFF_B_MIN}
RS37 b37 g37 0.01
RON37 g37 m37 100
VM37 m37 0 DC 0
D38 vdd a38 DB
VO38 a38 b38 DC {OFF_B_MIN}
RS38 b38 g38 0.01
RON38 g38 m38 40
VM38 m38 0 DC 0
D39 vdd a39 DB
VO39 a39 b39 DC {OFF_B_MID}
RS39 b39 g39 0.01
RON39 g39 m39 100
VM39 m39 0 DC 0
D40 vdd a40 DB
VO40 a40 b40 DC {OFF_B_MID}
RS40 b40 g40 0.01
RON40 g40 m40 40
VM40 m40 0 DC 0
D41 vdd a41 DB
VO41 a41 b41 DC {OFF_B_MAX}
RS41 b41 g41 0.01
RON41 g41 m41 100
VM41 m41 0 DC 0
D42 vdd a42 DB
VO42 a42 b42 DC {OFF_B_MAX}
RS42 b42 g42 0.01
RON42 g42 m42 40
VM42 m42 0 DC 0
.control
set width=200
dc VDD 2.4 3.3 0.1
print i(VM1)
print i(VM2)
print i(VM3)
print i(VM4)
print i(VM5)
print i(VM6)
print i(VM7)
print i(VM8)
print i(VM9)
print i(VM10)
print i(VM11)
print i(VM12)
print i(VM13)
print i(VM14)
print i(VM15)
print i(VM16)
print i(VM17)
print i(VM18)
print i(VM19)
print i(VM20)
print i(VM21)
print i(VM22)
print i(VM23)
print i(VM24)
print i(VM25)
print i(VM26)
print i(VM27)
print i(VM28)
print i(VM29)
print i(VM30)
print i(VM31)
print i(VM32)
print i(VM33)
print i(VM34)
print i(VM35)
print i(VM36)
print i(VM37)
print i(VM38)
print i(VM39)
print i(VM40)
print i(VM41)
print i(VM42)
.endc
.end
