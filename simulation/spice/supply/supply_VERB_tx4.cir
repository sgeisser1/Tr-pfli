* fluidi supply_burst - erzeugt von supply_burst.py
VOC ocv 0 DC 2.7
RINT ocv vbat 100
RHLD vbat vbat2 0.05
RFET vbat2 vdd 0.085
CB1 vdd cb1 8e-05 IC=2.7
RESR1 cb1 0 5m
CB2 vdd cb2 8e-05 IC=2.7
RESR2 cb2 0 5m
C5 vdd 0 5u IC=2.7
VPDC pdc 0 PWL(0 1.15e-06 0.001 1.15e-06 0.001001 0.0004 0.00154 0.0004 0.001541 0.0026 0.00304 0.0026 0.003041 0.0053 0.00349 0.0053 0.003491 0.0079 0.00409 0.0079 0.004091 1.15e-06 0.01054 1.15e-06 0.010541 0.0053 0.01099 0.0053 0.010991 0.0079 0.01159 0.0079 0.011591 1.15e-06 0.01804 1.15e-06 0.018041 0.0053 0.01849 0.0053 0.018491 0.0079 0.01909 0.0079 0.019091 1.15e-06 0.02554 1.15e-06 0.025541 0.0053 0.02599 0.0053 0.025991 0.0079 0.02659 0.0079 0.026591 1.15e-06 0.03304 1.15e-06 0.033041 0.0053 0.03349 0.0053 0.033491 0.0079 0.03409 0.0079 0.034091 1.15e-06 0.04054 1.15e-06 0.040541 0.0053 0.04099 0.0053 0.040991 0.0079 0.04159 0.0079 0.041591 1.15e-06 0.04804 1.15e-06 0.048041 0.0053 0.04849 0.0053 0.048491 0.0079 0.04909 0.0079 0.049091 1.15e-06 0.05554 1.15e-06 0.055541 0.0026 0.05629 0.0026 0.056291 1.15e-06)
VPLDO pldo 0 PWL(0 1.15e-06 0.001 1.15e-06 0.001001 0.0004 0.00154 0.0004 0.001541 0.0041 0.00304 0.0041 0.003041 0.009 0.00349 0.009 0.003491 0.0139412 0.00409 0.0139412 0.004091 1.15e-06 0.01054 1.15e-06 0.010541 0.009 0.01099 0.009 0.010991 0.0139412 0.01159 0.0139412 0.011591 1.15e-06 0.01804 1.15e-06 0.018041 0.009 0.01849 0.009 0.018491 0.0139412 0.01909 0.0139412 0.019091 1.15e-06 0.02554 1.15e-06 0.025541 0.009 0.02599 0.009 0.025991 0.0139412 0.02659 0.0139412 0.026591 1.15e-06 0.03304 1.15e-06 0.033041 0.009 0.03349 0.009 0.033491 0.0139412 0.03409 0.0139412 0.034091 1.15e-06 0.04054 1.15e-06 0.040541 0.009 0.04099 0.009 0.040991 0.0139412 0.04159 0.0139412 0.041591 1.15e-06 0.04804 1.15e-06 0.048041 0.009 0.04849 0.009 0.048491 0.0139412 0.04909 0.0139412 0.049091 1.15e-06 0.05554 1.15e-06 0.055541 0.0041 0.05629 0.0041 0.056291 1.15e-06)
VPCH pch 0 PWL(0 0 0.001 0 0.001001 0 0.00154 0 0.001541 0 0.00304 0 0.003041 0 0.00349 0 0.003491 0 0.00409 0 0.004091 0 0.01054 0 0.010541 0 0.01099 0 0.010991 0 0.01159 0 0.011591 0 0.01804 0 0.018041 0 0.01849 0 0.018491 0 0.01909 0 0.019091 0 0.02554 0 0.025541 0 0.02599 0 0.025991 0 0.02659 0 0.026591 0 0.03304 0 0.033041 0 0.03349 0 0.033491 0 0.03409 0 0.034091 0 0.04054 0 0.040541 0 0.04099 0 0.040991 0 0.04159 0 0.041591 0 0.04804 0 0.048041 0 0.04849 0 0.048491 0 0.04909 0 0.049091 0 0.05554 0 0.055541 0 0.05629 0 0.056291 0)
BCH vdd 0 I = v(pch)
BLOAD vdd 0 I = (1/(1+exp(-(v(vdd)-2.2)/0.005))) * v(pdc)*3.0/max(v(vdd),1.0) + (1-1/(1+exp(-(v(vdd)-2.2)/0.005))) * v(pldo)
.control
set wr_singlescale
set wr_vecnames
option numdgt=7
tran 2u 0.1063 uic
wrdata supply_VERB_tx4.dat v(vdd) v(vbat) i(VOC)
quit
.endc
.end
