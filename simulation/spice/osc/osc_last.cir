* fluidi osc_sim Rev B (D3) - erzeugt von osc_sim.py
VDD vdd 0 DC 3.0
RQ2 vdd opwr 0.1
C21 opwr 0 100n IC=3.0
C25 opwr 0 100n IC=3.0
EIN src 0 node 0 2
RT1 src t1 1k
T1 t1 0 t2 0 Z0=1k TD=4e-09
RT2 t2 0 1k
VONE one 0 DC 1
RST one st 1k
CST st 0 1f
SHY st 0 t2 0 SWHY
.model SWHY SW(VT=1.3375 VH=0.3475 RON=1 ROFF=1e9)
VIS opwr opx DC 0
SUP opx yint st 0 SWOUT
SDN yint 0 one st SWOUT
.model SWOUT SW(VT=0.5 VH=0 RON=40 ROFF=1e9)
CPD yint 0 22p
RY yint y 1m
COUT y 0 4.5e-12
R3 y node 10000
CNODE node 0 1.05e-11
CP0 node 0 7.049e-12
CPI node pm 9.9004e-11
CPS pm 0 1.3751e-10
RPS pm 0 147.17
C22 node p1 22p
Cp1 p1 0 6e-12
RLp1 p1 0 100Meg
.ic v(node)=0
.control
set wr_singlescale
set wr_vecnames
option numdgt=7
tran 0.1n 16u 0 0.1n uic
wrdata osc_last.dat v(y) v(node) v(opwr) i(VIS)
quit
.endc
.end
