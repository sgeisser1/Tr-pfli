* fluidi PL2303 RX - erzeugt von prog_uart.py (nicht von Hand aendern)
.include ../led_rgb/led_models.inc
VDD vdd 0 DC 2.2
VTX tx0 txo PWL(0 1.818 3.47222222e-05 1.818 3.47322222e-05 0 5.20833333e-05 0 5.20933333e-05 1.818 6.94444444e-05 1.818 6.94544444e-05 0 8.68055556e-05 0 8.68155556e-05 1.818 0.000104166667 1.818 0.000104176667 0 0.000121527778 0 0.000121537778 1.818 0.000138888889 1.818 0.000138898889 0 0.00015625 0 0.00015626 1.818 0.000173611111 1.818 0.000173621111 0 0.000190972222 0 0.000190982222 1.818 0.000208333333 1.818 0.000208343333 0 0.000225694444 0 0.000225704444 1.818 0.000243055556 1.818 0.000243065556 0 0.000260416667 0 0.000260426667 1.818 0.000277777778 1.818 0.000277787778 0 0.000295138889 0 0.000295148889 1.818 0.0003125 1.818 0.00031251 0 0.000329861111 0 0.000329871111 1.818 0.000347222222 1.818 0.000347232222 0 0.000364583333 0 0.000364593333 1.818 0.000381944444 1.818 0.000381954444 0 0.000538194444 0 0.000538204444 1.818 0.000555555556 1.818 0.000555565556 0 0.000572916667 0 0.000572926667 1.818 0.000729166667 1.818 0.000729176667 0 0.000746527778 0 0.000746537778 1.818 0.000763888889 1.818 0.000763898889 0 0.000885416667 0 0.000885426667 1.818 0.000902777778 1.818 0.000902787778 0 0.00104166667 0 0.00104167667 1.818 0.00107638889 1.818 0.00107639889 0 0.00112847222 0 0.00112848222 1.818 0.00116319444 1.818 0.00116320444 0 0.00119791667 0 0.00119792667 1.818 0.00125 1.818 0.00125001 0 0.00126736111 0 0.00126737111 1.818 0.00130208333 1.818 0.00130209333 0 0.00133680556 0 0.00133681556 1.818 0.00137152778 1.818 0.00137153778 0 0.00140625 0 0.00140626 1.818 0.00149305556 1.818 0.00149306556 0 0.00201388889 0 0.00201389889 1.818 0.00253472222 1.818)
VOL txo 0 DC 0.382495499867946
RTX tx0 tp2 200
CTP2 tp2 0 30p
R12 tp2 mid 100k
CMID mid 0 3p
R11 mid dio20 100k
CPIN dio20 0 9p
DBLED vdd aBLED DB
VOBLED aBLED bBLED DC {OFF_B_MIN}
RBLED bBLED dio20 100
CLED vdd aBLED 30p
.control
set wr_singlescale
set wr_vecnames
option numdgt=7
tran 4.34e-08 0.00253472 0 8.681e-08
wrdata prog_uart_pl2303_rx.dat v(dio20)
quit
.endc
.end
